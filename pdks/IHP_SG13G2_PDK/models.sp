.model nfet nmos l=1 w=1 nf=1 m=1  stack=1 parallel=1
.model pfet pmos l=1 w=1 nf=1 m=1  stack=1 parallel=1
.model nmos nmos l=1 w=1 nf=1 m=1  stack=1 parallel=1
.model pmos pmos l=1 w=1 nf=1 m=1  stack=1 parallel=1
.model nmos_rvt nmos l=1 w=1 nf=1 m=1  stack=1 parallel=1
.model pmos_rvt pmos l=1 w=1 nf=1 m=1  stack=1 parallel=1
.model resistor res r=1
.model capacitor cap l=1 w=1 m=1
.model inductor ind ind=1
